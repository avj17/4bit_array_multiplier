* NGSPICE file created from mult_array.ext - technology: ihp-sg13g2

* Black-box entry subcircuit for sg13g2_decap_8 abstract view
.subckt sg13g2_decap_8 VDD VSS
.ends

* Black-box entry subcircuit for sg13g2_dfrbpq_1 abstract view
.subckt sg13g2_dfrbpq_1 Q CLK D RESET_B VDD VSS
.ends

* Black-box entry subcircuit for sg13g2_nor3_1 abstract view
.subckt sg13g2_nor3_1 Y A B C VDD VSS
.ends

* Black-box entry subcircuit for sg13g2_fill_1 abstract view
.subckt sg13g2_fill_1 VDD VSS
.ends

* Black-box entry subcircuit for sg13g2_fill_2 abstract view
.subckt sg13g2_fill_2 VDD VSS
.ends

* Black-box entry subcircuit for sg13g2_a21oi_1 abstract view
.subckt sg13g2_a21oi_1 Y A1 A2 B1 VDD VSS
.ends

* Black-box entry subcircuit for sg13g2_dlygate4sd3_1 abstract view
.subckt sg13g2_dlygate4sd3_1 X A VDD VSS
.ends

* Black-box entry subcircuit for sg13g2_nand2_1 abstract view
.subckt sg13g2_nand2_1 Y A B VDD VSS
.ends

* Black-box entry subcircuit for sg13g2_or2_1 abstract view
.subckt sg13g2_or2_1 X A B VDD VSS
.ends

* Black-box entry subcircuit for sg13g2_buf_1 abstract view
.subckt sg13g2_buf_1 X A VDD VSS
.ends

* Black-box entry subcircuit for sg13g2_decap_4 abstract view
.subckt sg13g2_decap_4 VDD VSS
.ends

* Black-box entry subcircuit for sg13g2_and2_1 abstract view
.subckt sg13g2_and2_1 X A B VDD VSS
.ends

* Black-box entry subcircuit for sg13g2_xor2_1 abstract view
.subckt sg13g2_xor2_1 X A B VDD VSS
.ends

* Black-box entry subcircuit for sg13g2_buf_16 abstract view
.subckt sg13g2_buf_16 X A VDD VSS
.ends

* Black-box entry subcircuit for sg13g2_or3_1 abstract view
.subckt sg13g2_or3_1 X A B C VDD VSS
.ends

* Black-box entry subcircuit for sg13g2_nand2b_1 abstract view
.subckt sg13g2_nand2b_1 Y A_N B VDD VSS
.ends

* Black-box entry subcircuit for sg13g2_o21ai_1 abstract view
.subckt sg13g2_o21ai_1 Y A1 A2 B1 VDD VSS
.ends

* Black-box entry subcircuit for sg13g2_xnor2_1 abstract view
.subckt sg13g2_xnor2_1 Y A B VDD VSS
.ends

* Black-box entry subcircuit for sg13g2_inv_1 abstract view
.subckt sg13g2_inv_1 Y A VDD VSS
.ends

* Black-box entry subcircuit for sg13g2_and3_1 abstract view
.subckt sg13g2_and3_1 X A B C VDD VSS
.ends

* Black-box entry subcircuit for sg13g2_nor2_1 abstract view
.subckt sg13g2_nor2_1 Y A B VDD VSS
.ends

* Black-box entry subcircuit for sg13g2_mux2_1 abstract view
.subckt sg13g2_mux2_1 X A0 A1 S VDD VSS
.ends

* Black-box entry subcircuit for sg13g2_nor2b_1 abstract view
.subckt sg13g2_nor2b_1 Y A B_N VDD VSS
.ends

* Black-box entry subcircuit for sg13g2_nand4_1 abstract view
.subckt sg13g2_nand4_1 Y A B C D VDD VSS
.ends

* Black-box entry subcircuit for sg13g2_a22oi_1 abstract view
.subckt sg13g2_a22oi_1 Y A1 A2 B1 B2 VDD VSS
.ends

.subckt mult_array VGND VPWR a[0] a[1] a[2] a[3] b[0] b[1] b[2] b[3] clk p[0] p[1]
+ p[2] p[3] p[4] p[5] p[6] p[7] rst_n
XFILLER_22_144 VPWR VGND sg13g2_decap_8
XFILLER_7_7 VPWR VGND sg13g2_decap_8
XFILLER_13_100 VPWR VGND sg13g2_decap_8
XFILLER_13_155 VPWR VGND sg13g2_decap_8
XFILLER_26_63 VPWR VGND sg13g2_decap_8
XFILLER_9_126 VPWR VGND sg13g2_decap_8
XFILLER_3_56 VPWR VGND sg13g2_decap_8
XFILLER_27_203 VPWR VGND sg13g2_decap_8
XFILLER_12_21 VPWR VGND sg13g2_decap_8
XFILLER_12_98 VPWR VGND sg13g2_decap_8
XFILLER_18_225 VPWR VGND sg13g2_decap_8
XFILLER_26_280 VPWR VGND sg13g2_decap_8
XFILLER_24_217 VPWR VGND sg13g2_decap_8
XFILLER_5_173 VPWR VGND sg13g2_decap_8
XFILLER_5_140 VPWR VGND sg13g2_decap_8
XFILLER_23_42 VPWR VGND sg13g2_decap_8
X_131_ _131_/Q _133_/CLK _131_/D fanout18/X VPWR VGND sg13g2_dfrbpq_1
X_062_ _064_/B _062_/A _062_/B _062_/C VPWR VGND sg13g2_nor3_1
XFILLER_0_35 VPWR VGND sg13g2_decap_8
XFILLER_2_154 VPWR VGND sg13g2_decap_8
XFILLER_9_77 VPWR VGND sg13g2_decap_8
XFILLER_20_220 VPWR VGND sg13g2_fill_1
XFILLER_20_253 VPWR VGND sg13g2_decap_8
XFILLER_29_0 VPWR VGND sg13g2_decap_8
XFILLER_11_275 VPWR VGND sg13g2_decap_8
XFILLER_11_286 VPWR VGND sg13g2_fill_2
XFILLER_18_42 VPWR VGND sg13g2_decap_8
XFILLER_22_7 VPWR VGND sg13g2_decap_8
X_114_ _116_/B _107_/Y _110_/B _108_/A VPWR VGND sg13g2_a21oi_1
XFILLER_7_202 VPWR VGND sg13g2_decap_8
XFILLER_20_21 VPWR VGND sg13g2_decap_8
XFILLER_20_98 VPWR VGND sg13g2_decap_8
XFILLER_28_161 VPWR VGND sg13g2_decap_8
XFILLER_29_63 VPWR VGND sg13g2_decap_8
Xhold30 _113_/A _101_/Y VPWR VGND sg13g2_dlygate4sd3_1
XFILLER_19_172 VPWR VGND sg13g2_decap_8
XFILLER_6_56 VPWR VGND sg13g2_decap_8
XFILLER_15_21 VPWR VGND sg13g2_decap_8
XFILLER_17_109 VPWR VGND sg13g2_decap_8
XFILLER_25_175 VPWR VGND sg13g2_decap_8
XFILLER_16_120 VPWR VGND sg13g2_fill_2
XFILLER_11_0 VPWR VGND sg13g2_decap_8
XFILLER_22_123 VPWR VGND sg13g2_decap_8
XFILLER_26_42 VPWR VGND sg13g2_decap_8
XFILLER_9_105 VPWR VGND sg13g2_decap_8
XFILLER_3_35 VPWR VGND sg13g2_decap_8
XFILLER_12_77 VPWR VGND sg13g2_decap_8
XFILLER_18_204 VPWR VGND sg13g2_decap_8
XFILLER_27_259 VPWR VGND sg13g2_decap_8
XFILLER_17_281 VPWR VGND sg13g2_fill_2
XFILLER_23_21 VPWR VGND sg13g2_decap_8
X_130_ _130_/Q _133_/CLK _130_/D fanout18/X VPWR VGND sg13g2_dfrbpq_1
XFILLER_0_14 VPWR VGND sg13g2_decap_8
XFILLER_2_133 VPWR VGND sg13g2_decap_8
X_061_ _062_/C _129_/Q _133_/Q VPWR VGND sg13g2_nand2_1
XFILLER_9_56 VPWR VGND sg13g2_decap_8
XFILLER_20_232 VPWR VGND sg13g2_decap_8
XFILLER_11_254 VPWR VGND sg13g2_decap_8
XFILLER_18_21 VPWR VGND sg13g2_decap_8
XFILLER_18_98 VPWR VGND sg13g2_decap_8
X_113_ _116_/A _113_/A _113_/B VPWR VGND sg13g2_or2_1
XFILLER_7_269 VPWR VGND sg13g2_decap_8
XFILLER_15_7 VPWR VGND sg13g2_decap_8
XFILLER_20_77 VPWR VGND sg13g2_decap_8
XFILLER_28_140 VPWR VGND sg13g2_decap_8
XFILLER_29_42 VPWR VGND sg13g2_decap_8
Xhold31 hold31/X _116_/A VPWR VGND sg13g2_dlygate4sd3_1
XFILLER_4_239 VPWR VGND sg13g2_decap_8
XFILLER_6_35 VPWR VGND sg13g2_decap_8
XFILLER_25_154 VPWR VGND sg13g2_decap_8
XFILLER_0_275 VPWR VGND sg13g2_decap_8
XFILLER_0_286 VPWR VGND sg13g2_fill_2
XFILLER_16_176 VPWR VGND sg13g2_decap_8
Xoutput10 p[0] _120_/Q VPWR VGND sg13g2_buf_1
XFILLER_22_179 VPWR VGND sg13g2_decap_8
XFILLER_13_135 VPWR VGND sg13g2_decap_8
XFILLER_21_190 VPWR VGND sg13g2_decap_8
XFILLER_26_21 VPWR VGND sg13g2_decap_8
XFILLER_26_98 VPWR VGND sg13g2_decap_8
XFILLER_8_183 VPWR VGND sg13g2_decap_4
XFILLER_8_161 VPWR VGND sg13g2_decap_8
XFILLER_3_14 VPWR VGND sg13g2_decap_8
XFILLER_10_127 VPWR VGND sg13g2_decap_4
XFILLER_12_56 VPWR VGND sg13g2_decap_8
XFILLER_27_238 VPWR VGND sg13g2_decap_8
XFILLER_15_219 VPWR VGND sg13g2_decap_4
XFILLER_17_260 VPWR VGND sg13g2_decap_8
XFILLER_14_274 VPWR VGND sg13g2_decap_8
XFILLER_23_77 VPWR VGND sg13g2_decap_8
XFILLER_2_112 VPWR VGND sg13g2_decap_8
XFILLER_2_189 VPWR VGND sg13g2_decap_8
X_060_ _060_/X _129_/Q _133_/Q VPWR VGND sg13g2_and2_1
XFILLER_9_35 VPWR VGND sg13g2_decap_8
XFILLER_11_233 VPWR VGND sg13g2_decap_8
XFILLER_18_77 VPWR VGND sg13g2_decap_8
X_112_ _113_/B _088_/Y _093_/Y _102_/S VPWR VGND sg13g2_a21oi_1
XFILLER_1_0 VPWR VGND sg13g2_decap_8
XFILLER_1_91 VPWR VGND sg13g2_decap_8
XFILLER_20_56 VPWR VGND sg13g2_decap_8
XFILLER_29_119 VPWR VGND sg13g2_decap_8
XFILLER_4_218 VPWR VGND sg13g2_decap_8
XFILLER_28_196 VPWR VGND sg13g2_decap_8
XFILLER_29_21 VPWR VGND sg13g2_decap_8
XFILLER_29_98 VPWR VGND sg13g2_decap_8
Xhold21 _117_/A _111_/Y VPWR VGND sg13g2_dlygate4sd3_1
Xhold32 _100_/A _135_/Q VPWR VGND sg13g2_dlygate4sd3_1
XFILLER_6_14 VPWR VGND sg13g2_decap_8
XFILLER_3_273 VPWR VGND sg13g2_decap_8
XFILLER_19_130 VPWR VGND sg13g2_decap_8
XFILLER_0_254 VPWR VGND sg13g2_decap_8
XFILLER_15_56 VPWR VGND sg13g2_decap_8
XFILLER_16_155 VPWR VGND sg13g2_decap_8
XFILLER_25_133 VPWR VGND sg13g2_decap_8
Xoutput11 p[1] _121_/Q VPWR VGND sg13g2_buf_1
XFILLER_22_158 VPWR VGND sg13g2_decap_8
XFILLER_13_114 VPWR VGND sg13g2_decap_8
XFILLER_13_169 VPWR VGND sg13g2_decap_8
XFILLER_26_77 VPWR VGND sg13g2_decap_8
XFILLER_12_191 VPWR VGND sg13g2_decap_8
XFILLER_29_280 VPWR VGND sg13g2_decap_8
XFILLER_8_140 VPWR VGND sg13g2_decap_8
XFILLER_10_106 VPWR VGND sg13g2_decap_8
XFILLER_12_35 VPWR VGND sg13g2_decap_8
XFILLER_27_217 VPWR VGND sg13g2_decap_8
XFILLER_5_7 VPWR VGND sg13g2_decap_8
XFILLER_18_239 VPWR VGND sg13g2_decap_8
XFILLER_5_187 VPWR VGND sg13g2_decap_8
XFILLER_5_154 VPWR VGND sg13g2_fill_1
XFILLER_17_283 VPWR VGND sg13g2_fill_1
XFILLER_4_91 VPWR VGND sg13g2_decap_8
XFILLER_0_49 VPWR VGND sg13g2_decap_8
XFILLER_15_209 VPWR VGND sg13g2_fill_2
XFILLER_23_56 VPWR VGND sg13g2_decap_8
XFILLER_2_168 VPWR VGND sg13g2_decap_8
XFILLER_14_220 VPWR VGND sg13g2_decap_8
XFILLER_14_253 VPWR VGND sg13g2_decap_8
XFILLER_9_14 VPWR VGND sg13g2_decap_8
XFILLER_11_212 VPWR VGND sg13g2_decap_8
XFILLER_18_56 VPWR VGND sg13g2_decap_8
XFILLER_20_267 VPWR VGND sg13g2_decap_8
X_111_ _111_/Y _135_/Q _131_/Q VPWR VGND sg13g2_nand2_1
XFILLER_7_216 VPWR VGND sg13g2_decap_8
XFILLER_1_70 VPWR VGND sg13g2_decap_8
XFILLER_27_0 VPWR VGND sg13g2_decap_8
XFILLER_6_282 VPWR VGND sg13g2_decap_4
XFILLER_20_35 VPWR VGND sg13g2_decap_8
XFILLER_28_175 VPWR VGND sg13g2_decap_8
XFILLER_29_77 VPWR VGND sg13g2_decap_8
Xhold33 _080_/A _067_/Y VPWR VGND sg13g2_dlygate4sd3_1
XFILLER_3_252 VPWR VGND sg13g2_decap_8
XFILLER_19_186 VPWR VGND sg13g2_decap_8
XFILLER_20_7 VPWR VGND sg13g2_decap_8
XFILLER_0_233 VPWR VGND sg13g2_decap_8
XFILLER_15_35 VPWR VGND sg13g2_decap_8
XFILLER_25_112 VPWR VGND sg13g2_decap_8
XFILLER_25_189 VPWR VGND sg13g2_decap_8
Xoutput12 p[2] _122_/Q VPWR VGND sg13g2_buf_1
XFILLER_22_137 VPWR VGND sg13g2_decap_8
XFILLER_26_56 VPWR VGND sg13g2_decap_8
XFILLER_7_91 VPWR VGND sg13g2_decap_8
XFILLER_13_148 VPWR VGND sg13g2_decap_8
XFILLER_9_119 VPWR VGND sg13g2_decap_8
XFILLER_3_49 VPWR VGND sg13g2_decap_8
XFILLER_12_14 VPWR VGND sg13g2_decap_8
XFILLER_12_170 VPWR VGND sg13g2_decap_8
XFILLER_8_174 VPWR VGND sg13g2_decap_4
XFILLER_18_218 VPWR VGND sg13g2_decap_8
XFILLER_26_273 VPWR VGND sg13g2_decap_8
XFILLER_5_133 VPWR VGND sg13g2_decap_8
XFILLER_5_166 VPWR VGND sg13g2_decap_8
XFILLER_23_243 VPWR VGND sg13g2_decap_8
XFILLER_23_35 VPWR VGND sg13g2_decap_8
XFILLER_2_147 VPWR VGND sg13g2_decap_8
XFILLER_4_70 VPWR VGND sg13g2_decap_8
XFILLER_0_28 VPWR VGND sg13g2_decap_8
XFILLER_18_35 VPWR VGND sg13g2_decap_8
XFILLER_20_202 VPWR VGND sg13g2_decap_8
XFILLER_20_246 VPWR VGND sg13g2_decap_8
XFILLER_11_268 VPWR VGND sg13g2_decap_8
X_110_ _125_/D _110_/A _110_/B VPWR VGND sg13g2_xor2_1
XFILLER_6_261 VPWR VGND sg13g2_decap_8
XFILLER_20_14 VPWR VGND sg13g2_decap_8
XFILLER_28_154 VPWR VGND sg13g2_decap_8
XFILLER_29_56 VPWR VGND sg13g2_decap_8
Xhold34 _123_/D _080_/Y VPWR VGND sg13g2_dlygate4sd3_1
XFILLER_13_7 VPWR VGND sg13g2_decap_8
XFILLER_19_165 VPWR VGND sg13g2_decap_8
XFILLER_6_49 VPWR VGND sg13g2_decap_8
XFILLER_3_231 VPWR VGND sg13g2_decap_8
XFILLER_0_212 VPWR VGND sg13g2_decap_8
XFILLER_15_14 VPWR VGND sg13g2_decap_8
XFILLER_25_168 VPWR VGND sg13g2_decap_8
Xoutput13 p[3] _123_/Q VPWR VGND sg13g2_buf_1
XFILLER_16_102 VPWR VGND sg13g2_decap_8
XFILLER_15_190 VPWR VGND sg13g2_decap_8
XFILLER_30_193 VPWR VGND sg13g2_decap_8
XFILLER_7_70 VPWR VGND sg13g2_decap_8
XFILLER_26_35 VPWR VGND sg13g2_decap_8
XFILLER_3_28 VPWR VGND sg13g2_decap_8
XFILLER_26_252 VPWR VGND sg13g2_decap_8
XFILLER_17_274 VPWR VGND sg13g2_decap_8
XFILLER_23_14 VPWR VGND sg13g2_decap_8
XFILLER_23_222 VPWR VGND sg13g2_decap_8
XFILLER_23_277 VPWR VGND sg13g2_decap_8
XFILLER_2_126 VPWR VGND sg13g2_decap_8
XFILLER_9_49 VPWR VGND sg13g2_decap_8
XFILLER_20_225 VPWR VGND sg13g2_decap_8
XFILLER_11_247 VPWR VGND sg13g2_decap_8
XFILLER_18_14 VPWR VGND sg13g2_decap_8
XFILLER_6_240 VPWR VGND sg13g2_decap_8
XFILLER_28_133 VPWR VGND sg13g2_decap_8
XFILLER_29_35 VPWR VGND sg13g2_decap_8
XFILLER_19_144 VPWR VGND sg13g2_decap_4
XFILLER_6_28 VPWR VGND sg13g2_decap_8
XFILLER_3_287 VPWR VGND sg13g2_fill_1
XFILLER_3_210 VPWR VGND sg13g2_decap_8
XFILLER_25_147 VPWR VGND sg13g2_decap_8
XFILLER_0_268 VPWR VGND sg13g2_decap_8
XFILLER_16_169 VPWR VGND sg13g2_decap_8
XFILLER_21_91 VPWR VGND sg13g2_decap_8
Xoutput14 p[4] _124_/Q VPWR VGND sg13g2_buf_1
XFILLER_30_172 VPWR VGND sg13g2_decap_8
XFILLER_13_128 VPWR VGND sg13g2_decap_8
XFILLER_21_183 VPWR VGND sg13g2_decap_8
XFILLER_26_14 VPWR VGND sg13g2_decap_8
XFILLER_12_161 VPWR VGND sg13g2_fill_1
XFILLER_8_154 VPWR VGND sg13g2_decap_8
XFILLER_12_49 VPWR VGND sg13g2_decap_8
XFILLER_26_231 VPWR VGND sg13g2_decap_8
XFILLER_17_220 VPWR VGND sg13g2_decap_8
XFILLER_17_253 VPWR VGND sg13g2_decap_8
XFILLER_23_201 VPWR VGND sg13g2_decap_8
XFILLER_4_190 VPWR VGND sg13g2_decap_8
XFILLER_13_70 VPWR VGND sg13g2_fill_2
XFILLER_14_234 VPWR VGND sg13g2_decap_4
XFILLER_14_267 VPWR VGND sg13g2_decap_8
XFILLER_2_105 VPWR VGND sg13g2_decap_8
XFILLER_9_28 VPWR VGND sg13g2_decap_8
XFILLER_3_7 VPWR VGND sg13g2_decap_8
XFILLER_1_182 VPWR VGND sg13g2_decap_8
XFILLER_11_226 VPWR VGND sg13g2_decap_8
XFILLER_24_91 VPWR VGND sg13g2_decap_8
X_099_ _124_/D _099_/A _099_/B VPWR VGND sg13g2_xor2_1
XFILLER_1_84 VPWR VGND sg13g2_decap_8
XFILLER_20_49 VPWR VGND sg13g2_decap_8
XFILLER_28_112 VPWR VGND sg13g2_decap_8
XFILLER_29_14 VPWR VGND sg13g2_decap_8
Xhold25 _120_/D _062_/B VPWR VGND sg13g2_dlygate4sd3_1
XFILLER_10_60 VPWR VGND sg13g2_decap_8
XFILLER_19_123 VPWR VGND sg13g2_decap_8
XFILLER_19_91 VPWR VGND sg13g2_decap_8
XFILLER_28_189 VPWR VGND sg13g2_decap_8
XFILLER_3_266 VPWR VGND sg13g2_decap_8
XFILLER_15_49 VPWR VGND sg13g2_decap_8
XFILLER_25_0 VPWR VGND sg13g2_decap_8
XFILLER_25_126 VPWR VGND sg13g2_decap_8
XFILLER_0_247 VPWR VGND sg13g2_decap_8
XFILLER_16_126 VPWR VGND sg13g2_decap_4
Xoutput15 p[5] _125_/Q VPWR VGND sg13g2_buf_1
XFILLER_21_70 VPWR VGND sg13g2_decap_8
XFILLER_30_151 VPWR VGND sg13g2_decap_8
XFILLER_13_107 VPWR VGND sg13g2_decap_8
XFILLER_12_140 VPWR VGND sg13g2_decap_8
XFILLER_12_184 VPWR VGND sg13g2_decap_8
XFILLER_16_81 VPWR VGND sg13g2_decap_8
XFILLER_29_273 VPWR VGND sg13g2_decap_8
XFILLER_8_133 VPWR VGND sg13g2_decap_8
XFILLER_12_28 VPWR VGND sg13g2_decap_8
XFILLER_26_210 VPWR VGND sg13g2_decap_8
XFILLER_26_287 VPWR VGND sg13g2_fill_1
XFILLER_5_147 VPWR VGND sg13g2_decap_8
XFILLER_27_91 VPWR VGND sg13g2_decap_8
XFILLER_4_84 VPWR VGND sg13g2_decap_8
XFILLER_14_213 VPWR VGND sg13g2_decap_8
XFILLER_14_246 VPWR VGND sg13g2_decap_8
XFILLER_23_49 VPWR VGND sg13g2_decap_8
XFILLER_1_161 VPWR VGND sg13g2_decap_8
XFILLER_29_7 VPWR VGND sg13g2_decap_8
XFILLER_11_205 VPWR VGND sg13g2_decap_8
XFILLER_18_49 VPWR VGND sg13g2_decap_8
XFILLER_7_209 VPWR VGND sg13g2_decap_8
XFILLER_24_70 VPWR VGND sg13g2_decap_8
X_098_ _099_/B _098_/A _098_/B VPWR VGND sg13g2_nand2_1
XFILLER_6_286 VPWR VGND sg13g2_fill_2
XFILLER_6_275 VPWR VGND sg13g2_decap_8
XFILLER_1_63 VPWR VGND sg13g2_decap_8
XFILLER_20_28 VPWR VGND sg13g2_decap_8
XFILLER_28_168 VPWR VGND sg13g2_decap_8
Xhold37 hold37/X _065_/Y VPWR VGND sg13g2_dlygate4sd3_1
XFILLER_3_245 VPWR VGND sg13g2_decap_8
XFILLER_18_0 VPWR VGND sg13g2_decap_8
XFILLER_19_179 VPWR VGND sg13g2_decap_8
XFILLER_19_70 VPWR VGND sg13g2_decap_8
XFILLER_25_105 VPWR VGND sg13g2_decap_8
XFILLER_0_226 VPWR VGND sg13g2_decap_8
XFILLER_15_28 VPWR VGND sg13g2_decap_8
XFILLER_16_116 VPWR VGND sg13g2_decap_4
XFILLER_18_190 VPWR VGND sg13g2_decap_8
Xoutput16 p[6] _126_/Q VPWR VGND sg13g2_buf_1
XFILLER_11_7 VPWR VGND sg13g2_decap_8
XFILLER_24_182 VPWR VGND sg13g2_decap_8
XFILLER_30_130 VPWR VGND sg13g2_decap_8
Xclkbuf_0_clk clkbuf_0_clk/X clk VPWR VGND sg13g2_buf_16
XFILLER_21_152 VPWR VGND sg13g2_decap_8
XFILLER_26_49 VPWR VGND sg13g2_decap_8
XFILLER_7_84 VPWR VGND sg13g2_decap_8
XFILLER_16_60 VPWR VGND sg13g2_decap_8
XFILLER_29_252 VPWR VGND sg13g2_decap_8
XFILLER_8_112 VPWR VGND sg13g2_decap_8
XFILLER_26_266 VPWR VGND sg13g2_decap_8
XFILLER_5_159 VPWR VGND sg13g2_decap_8
XFILLER_5_126 VPWR VGND sg13g2_decap_8
XFILLER_27_70 VPWR VGND sg13g2_decap_8
XFILLER_4_63 VPWR VGND sg13g2_decap_8
XFILLER_23_236 VPWR VGND sg13g2_decap_8
XFILLER_23_28 VPWR VGND sg13g2_decap_8
XFILLER_13_72 VPWR VGND sg13g2_fill_1
XFILLER_1_140 VPWR VGND sg13g2_decap_8
XFILLER_18_28 VPWR VGND sg13g2_decap_8
XFILLER_20_239 VPWR VGND sg13g2_decap_8
XFILLER_10_283 VPWR VGND sg13g2_decap_4
XFILLER_1_42 VPWR VGND sg13g2_decap_8
X_097_ _098_/B _097_/A _105_/B _097_/C VPWR VGND sg13g2_or3_1
XFILLER_6_254 VPWR VGND sg13g2_decap_8
XFILLER_28_147 VPWR VGND sg13g2_decap_8
XFILLER_29_49 VPWR VGND sg13g2_decap_8
Xhold27 hold27/X _118_/Y VPWR VGND sg13g2_dlygate4sd3_1
Xhold38 _122_/D _066_/Y VPWR VGND sg13g2_dlygate4sd3_1
XFILLER_3_224 VPWR VGND sg13g2_decap_8
XFILLER_19_158 VPWR VGND sg13g2_decap_8
XFILLER_0_205 VPWR VGND sg13g2_decap_8
Xoutput17 p[7] _127_/Q VPWR VGND sg13g2_buf_1
XFILLER_24_161 VPWR VGND sg13g2_decap_8
XFILLER_15_183 VPWR VGND sg13g2_fill_2
XFILLER_26_28 VPWR VGND sg13g2_decap_8
XFILLER_30_0 VPWR VGND sg13g2_decap_8
XFILLER_30_186 VPWR VGND sg13g2_decap_8
XFILLER_7_63 VPWR VGND sg13g2_decap_8
XFILLER_21_131 VPWR VGND sg13g2_decap_8
XFILLER_21_197 VPWR VGND sg13g2_decap_8
XFILLER_29_231 VPWR VGND sg13g2_decap_8
XFILLER_8_168 VPWR VGND sg13g2_fill_1
XFILLER_26_245 VPWR VGND sg13g2_decap_8
XFILLER_17_267 VPWR VGND sg13g2_decap_8
Xclkbuf_2_0__f_clk _133_/CLK clkbuf_0_clk/X VPWR VGND sg13g2_buf_16
XFILLER_4_42 VPWR VGND sg13g2_decap_8
XFILLER_23_215 VPWR VGND sg13g2_decap_8
XFILLER_2_119 VPWR VGND sg13g2_decap_8
XFILLER_1_196 VPWR VGND sg13g2_decap_8
XFILLER_8_0 VPWR VGND sg13g2_decap_8
XFILLER_13_270 VPWR VGND sg13g2_decap_8
XFILLER_20_218 VPWR VGND sg13g2_fill_2
XFILLER_9_230 VPWR VGND sg13g2_decap_8
XFILLER_1_7 VPWR VGND sg13g2_decap_8
XFILLER_10_262 VPWR VGND sg13g2_decap_8
XFILLER_1_21 VPWR VGND sg13g2_decap_8
XFILLER_1_98 VPWR VGND sg13g2_decap_8
X_096_ _096_/Y _097_/A _105_/B _097_/C VPWR VGND sg13g2_nor3_1
XFILLER_6_233 VPWR VGND sg13g2_decap_8
XFILLER_28_126 VPWR VGND sg13g2_decap_8
XFILLER_29_28 VPWR VGND sg13g2_decap_8
Xhold28 _121_/D _119_/Y VPWR VGND sg13g2_dlygate4sd3_1
Xhold39 _081_/B _129_/Q VPWR VGND sg13g2_dlygate4sd3_1
XFILLER_10_74 VPWR VGND sg13g2_decap_4
XFILLER_19_137 VPWR VGND sg13g2_decap_8
XFILLER_3_203 VPWR VGND sg13g2_decap_8
XFILLER_2_280 VPWR VGND sg13g2_decap_8
X_079_ _099_/A _080_/A _080_/B VPWR VGND sg13g2_nand2b_1
XFILLER_21_84 VPWR VGND sg13g2_decap_8
XFILLER_24_140 VPWR VGND sg13g2_decap_8
XFILLER_15_162 VPWR VGND sg13g2_decap_8
XFILLER_23_0 VPWR VGND sg13g2_decap_8
XFILLER_30_165 VPWR VGND sg13g2_decap_8
XFILLER_7_42 VPWR VGND sg13g2_decap_8
XFILLER_21_176 VPWR VGND sg13g2_decap_8
XFILLER_29_210 VPWR VGND sg13g2_decap_8
XFILLER_29_287 VPWR VGND sg13g2_fill_1
XFILLER_12_154 VPWR VGND sg13g2_decap_8
XFILLER_12_198 VPWR VGND sg13g2_decap_8
XFILLER_16_95 VPWR VGND sg13g2_decap_8
XFILLER_8_147 VPWR VGND sg13g2_decap_8
XFILLER_26_224 VPWR VGND sg13g2_decap_8
XFILLER_17_213 VPWR VGND sg13g2_decap_8
XFILLER_17_246 VPWR VGND sg13g2_decap_8
XFILLER_4_98 VPWR VGND sg13g2_decap_8
XFILLER_4_21 VPWR VGND sg13g2_decap_8
XFILLER_4_183 VPWR VGND sg13g2_decap_8
XFILLER_13_63 VPWR VGND sg13g2_decap_8
XFILLER_14_227 VPWR VGND sg13g2_decap_8
XFILLER_1_175 VPWR VGND sg13g2_decap_8
XFILLER_11_219 VPWR VGND sg13g2_decap_8
XFILLER_1_77 VPWR VGND sg13g2_decap_8
XFILLER_24_84 VPWR VGND sg13g2_decap_8
XFILLER_27_7 VPWR VGND sg13g2_decap_8
X_095_ _098_/A _105_/B _097_/C _097_/A VPWR VGND sg13g2_o21ai_1
XFILLER_6_212 VPWR VGND sg13g2_decap_8
XFILLER_28_105 VPWR VGND sg13g2_decap_8
XFILLER_10_53 VPWR VGND sg13g2_decap_8
XFILLER_19_105 VPWR VGND sg13g2_fill_2
XFILLER_19_116 VPWR VGND sg13g2_decap_8
XFILLER_19_84 VPWR VGND sg13g2_decap_8
XFILLER_27_182 VPWR VGND sg13g2_decap_8
XFILLER_3_259 VPWR VGND sg13g2_decap_8
XFILLER_25_119 VPWR VGND sg13g2_decap_8
X_078_ _080_/B _078_/A _078_/B VPWR VGND sg13g2_xnor2_1
XFILLER_21_63 VPWR VGND sg13g2_decap_8
XFILLER_24_196 VPWR VGND sg13g2_decap_8
XFILLER_15_141 VPWR VGND sg13g2_decap_8
XFILLER_30_144 VPWR VGND sg13g2_decap_8
XFILLER_7_98 VPWR VGND sg13g2_decap_8
XFILLER_7_21 VPWR VGND sg13g2_decap_8
XFILLER_12_133 VPWR VGND sg13g2_decap_8
XFILLER_12_177 VPWR VGND sg13g2_decap_8
XFILLER_16_74 VPWR VGND sg13g2_decap_8
XFILLER_29_266 VPWR VGND sg13g2_decap_8
XFILLER_8_126 VPWR VGND sg13g2_decap_8
XFILLER_26_203 VPWR VGND sg13g2_decap_8
XFILLER_25_280 VPWR VGND sg13g2_decap_8
XFILLER_27_84 VPWR VGND sg13g2_decap_8
XFILLER_4_77 VPWR VGND sg13g2_decap_8
XFILLER_4_140 VPWR VGND sg13g2_decap_8
XFILLER_13_42 VPWR VGND sg13g2_decap_8
XFILLER_14_206 VPWR VGND sg13g2_decap_8
XFILLER_1_154 VPWR VGND sg13g2_decap_8
XFILLER_20_209 VPWR VGND sg13g2_decap_4
XFILLER_24_63 VPWR VGND sg13g2_decap_8
X_094_ _097_/C _094_/A _094_/B _094_/C VPWR VGND sg13g2_nor3_1
XFILLER_6_268 VPWR VGND sg13g2_decap_8
XFILLER_1_56 VPWR VGND sg13g2_decap_8
XFILLER_10_32 VPWR VGND sg13g2_decap_8
XFILLER_19_63 VPWR VGND sg13g2_decap_8
XFILLER_27_161 VPWR VGND sg13g2_decap_8
XFILLER_3_238 VPWR VGND sg13g2_decap_8
XFILLER_18_183 VPWR VGND sg13g2_decap_8
X_077_ _078_/B _077_/A _077_/B VPWR VGND sg13g2_xnor2_1
XFILLER_0_219 VPWR VGND sg13g2_decap_8
XFILLER_16_109 VPWR VGND sg13g2_decap_8
XFILLER_24_175 VPWR VGND sg13g2_decap_8
XFILLER_15_197 VPWR VGND sg13g2_decap_8
XFILLER_21_42 VPWR VGND sg13g2_decap_8
XFILLER_30_112 VPWR VGND sg13g2_fill_2
XFILLER_30_123 VPWR VGND sg13g2_decap_8
XFILLER_7_77 VPWR VGND sg13g2_decap_8
XFILLER_21_145 VPWR VGND sg13g2_decap_8
X_129_ _129_/Q _129_/CLK _129_/D fanout18/X VPWR VGND sg13g2_dfrbpq_1
XFILLER_12_112 VPWR VGND sg13g2_decap_8
XFILLER_16_53 VPWR VGND sg13g2_decap_8
XFILLER_29_245 VPWR VGND sg13g2_decap_8
XFILLER_8_105 VPWR VGND sg13g2_decap_8
XFILLER_7_182 VPWR VGND sg13g2_fill_1
XFILLER_26_259 VPWR VGND sg13g2_decap_8
XFILLER_27_63 VPWR VGND sg13g2_decap_8
XFILLER_23_229 VPWR VGND sg13g2_decap_8
XFILLER_4_56 VPWR VGND sg13g2_decap_8
XFILLER_13_21 VPWR VGND sg13g2_decap_8
XFILLER_13_284 VPWR VGND sg13g2_decap_4
XFILLER_1_133 VPWR VGND sg13g2_decap_8
XFILLER_22_284 VPWR VGND sg13g2_decap_4
XFILLER_9_277 VPWR VGND sg13g2_fill_2
XFILLER_9_244 VPWR VGND sg13g2_decap_4
XFILLER_10_210 VPWR VGND sg13g2_decap_4
XFILLER_10_276 VPWR VGND sg13g2_decap_8
XFILLER_10_287 VPWR VGND sg13g2_fill_1
XFILLER_24_42 VPWR VGND sg13g2_decap_8
X_093_ _093_/Y _094_/A _094_/C _094_/B VPWR VGND sg13g2_o21ai_1
XFILLER_6_247 VPWR VGND sg13g2_decap_8
XFILLER_6_0 VPWR VGND sg13g2_decap_8
XFILLER_1_35 VPWR VGND sg13g2_decap_8
XFILLER_10_11 VPWR VGND sg13g2_decap_8
XFILLER_19_42 VPWR VGND sg13g2_decap_8
Xinput1 _128_/D a[0] VPWR VGND sg13g2_buf_1
XFILLER_3_217 VPWR VGND sg13g2_decap_8
XFILLER_27_140 VPWR VGND sg13g2_decap_8
X_076_ _092_/A _077_/A _077_/B VPWR VGND sg13g2_nand2_1
XFILLER_18_162 VPWR VGND sg13g2_decap_8
XFILLER_15_121 VPWR VGND sg13g2_decap_8
XFILLER_15_176 VPWR VGND sg13g2_decap_8
XFILLER_21_21 VPWR VGND sg13g2_decap_8
XFILLER_21_98 VPWR VGND sg13g2_fill_2
XFILLER_24_154 VPWR VGND sg13g2_decap_8
XFILLER_21_124 VPWR VGND sg13g2_decap_8
XFILLER_30_179 VPWR VGND sg13g2_decap_8
X_128_ _128_/Q _129_/CLK _128_/D input9/X VPWR VGND sg13g2_dfrbpq_1
X_059_ _062_/B _059_/A VPWR VGND sg13g2_inv_1
XFILLER_7_56 VPWR VGND sg13g2_decap_8
XFILLER_16_32 VPWR VGND sg13g2_decap_8
XFILLER_29_224 VPWR VGND sg13g2_decap_8
XFILLER_7_161 VPWR VGND sg13g2_decap_8
XFILLER_21_0 VPWR VGND sg13g2_decap_8
XFILLER_26_238 VPWR VGND sg13g2_decap_8
XFILLER_17_227 VPWR VGND sg13g2_decap_8
XFILLER_27_42 VPWR VGND sg13g2_decap_8
XFILLER_4_35 VPWR VGND sg13g2_decap_8
XFILLER_4_197 VPWR VGND sg13g2_decap_8
XFILLER_23_208 VPWR VGND sg13g2_decap_8
XFILLER_1_112 VPWR VGND sg13g2_decap_8
XFILLER_1_189 VPWR VGND sg13g2_decap_8
XFILLER_22_230 VPWR VGND sg13g2_decap_8
XFILLER_13_263 VPWR VGND sg13g2_decap_8
XFILLER_9_223 VPWR VGND sg13g2_decap_8
XFILLER_10_255 VPWR VGND sg13g2_decap_8
XFILLER_24_21 VPWR VGND sg13g2_decap_8
XFILLER_24_98 VPWR VGND sg13g2_decap_8
XFILLER_6_226 VPWR VGND sg13g2_decap_8
XFILLER_1_14 VPWR VGND sg13g2_decap_8
X_092_ _105_/B _092_/A _094_/B _092_/C VPWR VGND sg13g2_and3_1
XFILLER_10_67 VPWR VGND sg13g2_decap_8
XFILLER_10_78 VPWR VGND sg13g2_fill_1
XFILLER_28_119 VPWR VGND sg13g2_decap_8
Xinput2 _129_/D a[1] VPWR VGND sg13g2_buf_1
XFILLER_19_21 VPWR VGND sg13g2_decap_8
XFILLER_19_98 VPWR VGND sg13g2_decap_8
XFILLER_25_7 VPWR VGND sg13g2_decap_8
XFILLER_27_196 VPWR VGND sg13g2_decap_8
XFILLER_2_273 VPWR VGND sg13g2_decap_8
X_075_ _094_/A _077_/A _077_/B VPWR VGND sg13g2_nor2_1
XFILLER_18_141 VPWR VGND sg13g2_fill_1
XFILLER_15_100 VPWR VGND sg13g2_decap_8
XFILLER_21_77 VPWR VGND sg13g2_decap_8
XFILLER_24_133 VPWR VGND sg13g2_decap_8
XFILLER_15_155 VPWR VGND sg13g2_decap_8
XFILLER_30_114 VPWR VGND sg13g2_fill_1
XFILLER_30_158 VPWR VGND sg13g2_decap_8
X_127_ _127_/Q _135_/CLK _127_/D fanout18/X VPWR VGND sg13g2_dfrbpq_1
X_058_ _059_/A _128_/Q _132_/Q VPWR VGND sg13g2_nand2_1
XFILLER_7_35 VPWR VGND sg13g2_decap_8
XFILLER_12_147 VPWR VGND sg13g2_decap_8
XFILLER_16_11 VPWR VGND sg13g2_decap_8
XFILLER_16_88 VPWR VGND sg13g2_decap_8
XFILLER_29_203 VPWR VGND sg13g2_decap_8
XFILLER_28_280 VPWR VGND sg13g2_decap_8
XFILLER_7_140 VPWR VGND sg13g2_decap_8
XFILLER_26_217 VPWR VGND sg13g2_decap_8
XFILLER_7_195 VPWR VGND sg13g2_decap_8
XFILLER_17_206 VPWR VGND sg13g2_decap_8
XFILLER_17_239 VPWR VGND sg13g2_decap_8
XFILLER_27_21 VPWR VGND sg13g2_decap_8
XFILLER_27_98 VPWR VGND sg13g2_decap_8
XFILLER_4_176 VPWR VGND sg13g2_decap_8
XFILLER_4_14 VPWR VGND sg13g2_decap_8
XFILLER_13_56 VPWR VGND sg13g2_decap_8
XFILLER_1_168 VPWR VGND sg13g2_decap_8
XFILLER_13_242 VPWR VGND sg13g2_decap_8
XFILLER_9_279 VPWR VGND sg13g2_fill_1
XFILLER_9_202 VPWR VGND sg13g2_decap_8
XFILLER_24_77 VPWR VGND sg13g2_decap_8
X_091_ _094_/C _077_/A _077_/B _078_/A VPWR VGND sg13g2_a21oi_1
XFILLER_6_205 VPWR VGND sg13g2_decap_8
Xinput3 _130_/D a[2] VPWR VGND sg13g2_buf_1
XFILLER_5_271 VPWR VGND sg13g2_decap_8
XFILLER_10_46 VPWR VGND sg13g2_decap_8
XFILLER_19_77 VPWR VGND sg13g2_decap_8
XFILLER_27_175 VPWR VGND sg13g2_decap_8
X_074_ _077_/B _074_/A _074_/B VPWR VGND sg13g2_xor2_1
XFILLER_18_197 VPWR VGND sg13g2_decap_8
XFILLER_18_7 VPWR VGND sg13g2_decap_8
XFILLER_2_252 VPWR VGND sg13g2_decap_8
XFILLER_21_56 VPWR VGND sg13g2_decap_8
XFILLER_24_112 VPWR VGND sg13g2_decap_8
XFILLER_24_189 VPWR VGND sg13g2_decap_8
XFILLER_2_91 VPWR VGND sg13g2_decap_8
XFILLER_16_4 VPWR VGND sg13g2_decap_8
XFILLER_30_137 VPWR VGND sg13g2_decap_8
X_126_ _126_/Q _135_/CLK _126_/D fanout18/X VPWR VGND sg13g2_dfrbpq_1
X_057_ _062_/A _132_/Q _130_/Q VPWR VGND sg13g2_nand2_1
XFILLER_7_14 VPWR VGND sg13g2_decap_8
XFILLER_21_159 VPWR VGND sg13g2_decap_8
XFILLER_29_259 VPWR VGND sg13g2_decap_8
XFILLER_12_126 VPWR VGND sg13g2_decap_8
XFILLER_16_67 VPWR VGND sg13g2_decap_8
XFILLER_20_181 VPWR VGND sg13g2_decap_8
XFILLER_8_119 VPWR VGND sg13g2_decap_8
XFILLER_11_181 VPWR VGND sg13g2_decap_8
XFILLER_19_270 VPWR VGND sg13g2_decap_8
X_109_ _110_/B _099_/A _096_/Y _098_/A VPWR VGND sg13g2_o21ai_1
XFILLER_25_273 VPWR VGND sg13g2_decap_8
XFILLER_27_77 VPWR VGND sg13g2_decap_8
XFILLER_16_284 VPWR VGND sg13g2_decap_4
XFILLER_4_133 VPWR VGND sg13g2_decap_8
XFILLER_13_35 VPWR VGND sg13g2_decap_8
XFILLER_1_147 VPWR VGND sg13g2_decap_8
XFILLER_13_221 VPWR VGND sg13g2_decap_8
XFILLER_0_191 VPWR VGND sg13g2_decap_8
XFILLER_5_91 VPWR VGND sg13g2_decap_8
XFILLER_1_49 VPWR VGND sg13g2_decap_8
XFILLER_24_56 VPWR VGND sg13g2_decap_8
X_090_ _092_/C _077_/A _077_/B _078_/A VPWR VGND sg13g2_o21ai_1
Xclkbuf_2_1__f_clk _135_/CLK clkbuf_0_clk/X VPWR VGND sg13g2_buf_16
Xinput4 _131_/D a[3] VPWR VGND sg13g2_buf_1
XFILLER_5_250 VPWR VGND sg13g2_decap_8
XFILLER_10_25 VPWR VGND sg13g2_decap_8
XFILLER_19_56 VPWR VGND sg13g2_decap_8
XFILLER_27_154 VPWR VGND sg13g2_decap_8
XFILLER_18_176 VPWR VGND sg13g2_decap_8
XFILLER_2_231 VPWR VGND sg13g2_decap_8
X_073_ _074_/B _071_/X _072_/Y _073_/S VPWR VGND sg13g2_mux2_1
XFILLER_4_0 VPWR VGND sg13g2_decap_8
XFILLER_21_35 VPWR VGND sg13g2_decap_8
XFILLER_24_168 VPWR VGND sg13g2_decap_8
XFILLER_2_70 VPWR VGND sg13g2_decap_8
XFILLER_15_135 VPWR VGND sg13g2_fill_2
XFILLER_30_105 VPWR VGND sg13g2_decap_8
XFILLER_30_7 VPWR VGND sg13g2_decap_8
X_125_ _125_/Q _125_/CLK _125_/D fanout19/X VPWR VGND sg13g2_dfrbpq_1
X_056_ _064_/A _128_/Q _134_/Q VPWR VGND sg13g2_nand2_1
XFILLER_21_138 VPWR VGND sg13g2_decap_8
XFILLER_12_105 VPWR VGND sg13g2_decap_8
XFILLER_16_46 VPWR VGND sg13g2_decap_8
XFILLER_29_238 VPWR VGND sg13g2_decap_8
XFILLER_11_160 VPWR VGND sg13g2_decap_8
X_108_ _110_/A _108_/A _107_/Y VPWR VGND sg13g2_nor2b_1
XFILLER_7_175 VPWR VGND sg13g2_decap_8
XFILLER_25_252 VPWR VGND sg13g2_decap_8
XFILLER_27_56 VPWR VGND sg13g2_decap_8
XFILLER_8_91 VPWR VGND sg13g2_decap_8
XFILLER_4_49 VPWR VGND sg13g2_decap_8
XFILLER_4_112 VPWR VGND sg13g2_decap_8
XFILLER_13_14 VPWR VGND sg13g2_decap_8
XFILLER_22_244 VPWR VGND sg13g2_decap_4
XFILLER_22_277 VPWR VGND sg13g2_decap_8
XFILLER_13_200 VPWR VGND sg13g2_decap_8
XFILLER_13_277 VPWR VGND sg13g2_decap_8
XFILLER_1_126 VPWR VGND sg13g2_decap_8
XFILLER_9_248 VPWR VGND sg13g2_fill_2
XFILLER_9_237 VPWR VGND sg13g2_decap_8
XFILLER_8_7 VPWR VGND sg13g2_decap_8
XFILLER_0_170 VPWR VGND sg13g2_decap_8
XFILLER_8_281 VPWR VGND sg13g2_decap_8
XFILLER_5_70 VPWR VGND sg13g2_decap_8
XFILLER_10_203 VPWR VGND sg13g2_decap_8
XFILLER_10_269 VPWR VGND sg13g2_decap_8
XFILLER_1_28 VPWR VGND sg13g2_decap_8
XFILLER_24_35 VPWR VGND sg13g2_decap_8
Xinput5 _132_/D b[0] VPWR VGND sg13g2_buf_1
XFILLER_19_35 VPWR VGND sg13g2_decap_8
XFILLER_27_133 VPWR VGND sg13g2_decap_8
XFILLER_18_155 VPWR VGND sg13g2_decap_8
XFILLER_2_210 VPWR VGND sg13g2_decap_8
XFILLER_2_287 VPWR VGND sg13g2_fill_1
X_072_ _072_/Y _128_/Q _129_/Q _132_/Q _133_/Q VPWR VGND sg13g2_nand4_1
XFILLER_24_147 VPWR VGND sg13g2_decap_8
XFILLER_15_114 VPWR VGND sg13g2_decap_8
XFILLER_15_169 VPWR VGND sg13g2_decap_8
XFILLER_21_14 VPWR VGND sg13g2_decap_8
XFILLER_23_180 VPWR VGND sg13g2_decap_8
X_124_ _124_/Q _125_/CLK _124_/D fanout19/X VPWR VGND sg13g2_dfrbpq_1
XFILLER_7_49 VPWR VGND sg13g2_decap_8
XFILLER_11_91 VPWR VGND sg13g2_decap_8
XFILLER_21_117 VPWR VGND sg13g2_decap_8
XFILLER_23_7 VPWR VGND sg13g2_decap_8
XFILLER_16_25 VPWR VGND sg13g2_decap_8
XFILLER_20_150 VPWR VGND sg13g2_decap_8
XFILLER_29_217 VPWR VGND sg13g2_decap_8
X_107_ _107_/Y _106_/B _106_/C _106_/A VPWR VGND sg13g2_o21ai_1
XFILLER_7_154 VPWR VGND sg13g2_decap_8
XFILLER_27_35 VPWR VGND sg13g2_decap_8
XFILLER_8_70 VPWR VGND sg13g2_decap_8
XFILLER_25_231 VPWR VGND sg13g2_decap_8
XFILLER_4_28 VPWR VGND sg13g2_decap_8
XFILLER_12_0 VPWR VGND sg13g2_decap_8
XFILLER_22_223 VPWR VGND sg13g2_decap_8
XFILLER_13_256 VPWR VGND sg13g2_decap_8
XFILLER_1_105 VPWR VGND sg13g2_decap_8
XFILLER_9_216 VPWR VGND sg13g2_decap_8
XFILLER_10_248 VPWR VGND sg13g2_decap_8
XFILLER_24_14 VPWR VGND sg13g2_decap_8
XFILLER_6_219 VPWR VGND sg13g2_decap_8
XFILLER_5_285 VPWR VGND sg13g2_fill_2
XFILLER_19_14 VPWR VGND sg13g2_decap_8
Xinput6 _133_/D b[1] VPWR VGND sg13g2_buf_1
XFILLER_18_112 VPWR VGND sg13g2_decap_8
XFILLER_18_134 VPWR VGND sg13g2_decap_8
XFILLER_27_112 VPWR VGND sg13g2_decap_8
XFILLER_27_189 VPWR VGND sg13g2_decap_8
XFILLER_2_266 VPWR VGND sg13g2_decap_8
X_071_ _071_/X _129_/Q _132_/Q VPWR VGND sg13g2_and2_1
XFILLER_24_126 VPWR VGND sg13g2_decap_8
XFILLER_15_148 VPWR VGND sg13g2_decap_8
XFILLER_11_70 VPWR VGND sg13g2_decap_8
X_123_ _123_/Q _125_/CLK _123_/D fanout19/X VPWR VGND sg13g2_dfrbpq_1
XFILLER_7_28 VPWR VGND sg13g2_decap_8
XFILLER_20_195 VPWR VGND sg13g2_decap_8
XFILLER_22_91 VPWR VGND sg13g2_decap_4
XFILLER_28_273 VPWR VGND sg13g2_decap_8
X_106_ _108_/A _106_/A _106_/B _106_/C VPWR VGND sg13g2_nor3_1
XFILLER_7_188 VPWR VGND sg13g2_decap_8
XFILLER_7_133 VPWR VGND sg13g2_decap_8
XFILLER_14_4 VPWR VGND sg13g2_decap_8
XFILLER_19_284 VPWR VGND sg13g2_decap_4
XFILLER_25_210 VPWR VGND sg13g2_decap_8
XFILLER_25_287 VPWR VGND sg13g2_fill_1
XFILLER_27_14 VPWR VGND sg13g2_decap_8
XFILLER_4_147 VPWR VGND sg13g2_fill_2
XFILLER_13_49 VPWR VGND sg13g2_decap_8
XFILLER_22_202 VPWR VGND sg13g2_decap_8
XFILLER_13_235 VPWR VGND sg13g2_decap_8
XFILLER_14_81 VPWR VGND sg13g2_decap_8
XFILLER_5_264 VPWR VGND sg13g2_decap_8
XFILLER_10_39 VPWR VGND sg13g2_decap_8
XFILLER_30_91 VPWR VGND sg13g2_decap_8
Xinput7 _134_/D b[2] VPWR VGND sg13g2_buf_1
XFILLER_27_168 VPWR VGND sg13g2_decap_8
XFILLER_2_245 VPWR VGND sg13g2_decap_8
X_070_ _073_/S _130_/Q _133_/Q VPWR VGND sg13g2_nand2_1
XFILLER_25_91 VPWR VGND sg13g2_decap_8
XFILLER_2_84 VPWR VGND sg13g2_decap_8
XFILLER_21_49 VPWR VGND sg13g2_decap_8
XFILLER_24_105 VPWR VGND sg13g2_decap_8
XFILLER_21_108 VPWR VGND sg13g2_fill_1
XFILLER_2_0 VPWR VGND sg13g2_decap_8
X_122_ _122_/Q _125_/CLK _122_/D fanout19/X VPWR VGND sg13g2_dfrbpq_1
XFILLER_12_119 VPWR VGND sg13g2_decap_8
XFILLER_14_160 VPWR VGND sg13g2_decap_8
XFILLER_11_174 VPWR VGND sg13g2_decap_8
XFILLER_20_174 VPWR VGND sg13g2_decap_8
XFILLER_22_70 VPWR VGND sg13g2_decap_8
XFILLER_28_252 VPWR VGND sg13g2_decap_8
X_105_ _106_/C _105_/A _105_/B _105_/C VPWR VGND sg13g2_nor3_1
XFILLER_7_112 VPWR VGND sg13g2_decap_8
XFILLER_19_263 VPWR VGND sg13g2_decap_8
XFILLER_25_266 VPWR VGND sg13g2_decap_8
XFILLER_4_126 VPWR VGND sg13g2_decap_8
XFILLER_16_211 VPWR VGND sg13g2_decap_8
XFILLER_16_277 VPWR VGND sg13g2_decap_8
XFILLER_13_28 VPWR VGND sg13g2_decap_8
Xfanout18 fanout18/X fanout19/X VPWR VGND sg13g2_buf_1
XFILLER_0_184 VPWR VGND sg13g2_decap_8
XFILLER_13_214 VPWR VGND sg13g2_decap_8
XFILLER_28_91 VPWR VGND sg13g2_decap_8
XFILLER_24_49 VPWR VGND sg13g2_decap_8
XFILLER_5_84 VPWR VGND sg13g2_decap_8
XFILLER_14_60 VPWR VGND sg13g2_decap_8
XFILLER_6_7 VPWR VGND sg13g2_decap_8
XFILLER_30_70 VPWR VGND sg13g2_decap_8
Xinput8 _135_/D b[3] VPWR VGND sg13g2_buf_1
XFILLER_5_287 VPWR VGND sg13g2_fill_1
XFILLER_5_243 VPWR VGND sg13g2_decap_8
XFILLER_10_18 VPWR VGND sg13g2_decap_8
XFILLER_19_49 VPWR VGND sg13g2_decap_8
XFILLER_27_147 VPWR VGND sg13g2_decap_8
XFILLER_18_147 VPWR VGND sg13g2_fill_2
XFILLER_18_169 VPWR VGND sg13g2_decap_8
XFILLER_25_70 VPWR VGND sg13g2_decap_8
XFILLER_2_224 VPWR VGND sg13g2_decap_8
XFILLER_17_180 VPWR VGND sg13g2_decap_4
XFILLER_17_191 VPWR VGND sg13g2_fill_2
XFILLER_21_28 VPWR VGND sg13g2_decap_8
XFILLER_2_63 VPWR VGND sg13g2_decap_8
XFILLER_15_128 VPWR VGND sg13g2_decap_8
XFILLER_23_194 VPWR VGND sg13g2_decap_8
X_121_ _121_/Q _129_/CLK _121_/D fanout19/X VPWR VGND sg13g2_dfrbpq_1
XFILLER_16_39 VPWR VGND sg13g2_decap_8
XFILLER_28_0 VPWR VGND sg13g2_decap_8
XFILLER_28_231 VPWR VGND sg13g2_decap_8
XFILLER_11_153 VPWR VGND sg13g2_decap_8
XFILLER_19_242 VPWR VGND sg13g2_decap_8
XFILLER_21_7 VPWR VGND sg13g2_decap_8
X_104_ _106_/B _088_/Y _093_/Y _103_/Y VPWR VGND sg13g2_a21oi_1
XFILLER_7_168 VPWR VGND sg13g2_decap_8
XFILLER_25_245 VPWR VGND sg13g2_decap_8
XFILLER_27_49 VPWR VGND sg13g2_decap_8
XFILLER_8_84 VPWR VGND sg13g2_decap_8
XFILLER_4_105 VPWR VGND sg13g2_decap_8
XFILLER_17_60 VPWR VGND sg13g2_decap_8
XFILLER_1_119 VPWR VGND sg13g2_decap_8
XFILLER_22_237 VPWR VGND sg13g2_decap_8
XFILLER_22_248 VPWR VGND sg13g2_fill_2
XFILLER_30_270 VPWR VGND sg13g2_decap_8
Xfanout19 fanout19/X input9/X VPWR VGND sg13g2_buf_1
XFILLER_3_182 VPWR VGND sg13g2_decap_8
XFILLER_0_163 VPWR VGND sg13g2_decap_8
XFILLER_28_70 VPWR VGND sg13g2_decap_8
XFILLER_8_274 VPWR VGND sg13g2_decap_8
XFILLER_8_241 VPWR VGND sg13g2_fill_2
XFILLER_8_230 VPWR VGND sg13g2_decap_8
XFILLER_5_63 VPWR VGND sg13g2_decap_8
XFILLER_24_28 VPWR VGND sg13g2_decap_8
Xinput9 input9/X rst_n VPWR VGND sg13g2_buf_1
XFILLER_5_222 VPWR VGND sg13g2_decap_8
XFILLER_19_28 VPWR VGND sg13g2_decap_8
XFILLER_27_126 VPWR VGND sg13g2_decap_8
XFILLER_2_203 VPWR VGND sg13g2_decap_8
XFILLER_1_280 VPWR VGND sg13g2_decap_8
XFILLER_2_42 VPWR VGND sg13g2_decap_8
XFILLER_11_84 VPWR VGND sg13g2_decap_8
XFILLER_15_107 VPWR VGND sg13g2_decap_8
XFILLER_23_173 VPWR VGND sg13g2_decap_8
X_120_ _120_/Q _129_/CLK _120_/D fanout19/X VPWR VGND sg13g2_dfrbpq_1
XFILLER_16_18 VPWR VGND sg13g2_decap_8
XFILLER_20_143 VPWR VGND sg13g2_decap_8
XFILLER_28_210 VPWR VGND sg13g2_decap_8
XFILLER_19_221 VPWR VGND sg13g2_decap_8
XFILLER_28_287 VPWR VGND sg13g2_fill_1
X_103_ _103_/Y _105_/C VPWR VGND sg13g2_inv_1
XFILLER_7_147 VPWR VGND sg13g2_decap_8
XFILLER_25_224 VPWR VGND sg13g2_decap_8
XFILLER_27_28 VPWR VGND sg13g2_decap_8
XFILLER_8_63 VPWR VGND sg13g2_decap_8
XFILLER_6_191 VPWR VGND sg13g2_decap_8
XFILLER_22_216 VPWR VGND sg13g2_decap_8
XFILLER_3_161 VPWR VGND sg13g2_decap_8
XFILLER_13_249 VPWR VGND sg13g2_decap_8
XFILLER_21_282 VPWR VGND sg13g2_decap_4
XFILLER_9_209 VPWR VGND sg13g2_decap_8
XFILLER_0_131 VPWR VGND sg13g2_decap_8
XFILLER_5_42 VPWR VGND sg13g2_decap_8
XFILLER_14_95 VPWR VGND sg13g2_decap_8
XFILLER_5_278 VPWR VGND sg13g2_decap_8
XFILLER_5_201 VPWR VGND sg13g2_decap_8
XFILLER_27_105 VPWR VGND sg13g2_decap_8
XFILLER_18_105 VPWR VGND sg13g2_decap_8
XFILLER_26_182 VPWR VGND sg13g2_decap_8
XFILLER_2_259 VPWR VGND sg13g2_decap_8
XFILLER_17_193 VPWR VGND sg13g2_fill_1
XFILLER_24_119 VPWR VGND sg13g2_decap_8
XFILLER_2_21 VPWR VGND sg13g2_decap_8
XFILLER_2_98 VPWR VGND sg13g2_decap_8
XFILLER_23_152 VPWR VGND sg13g2_decap_8
XFILLER_11_63 VPWR VGND sg13g2_decap_8
XFILLER_20_188 VPWR VGND sg13g2_decap_8
XFILLER_0_0 VPWR VGND sg13g2_decap_8
XFILLER_11_188 VPWR VGND sg13g2_decap_8
XFILLER_19_200 VPWR VGND sg13g2_decap_4
XFILLER_22_84 VPWR VGND sg13g2_decap_8
XFILLER_22_95 VPWR VGND sg13g2_fill_1
XFILLER_28_266 VPWR VGND sg13g2_decap_8
X_102_ _105_/C _101_/Y _134_/Q _102_/S VPWR VGND sg13g2_mux2_1
Xclkbuf_2_2__f_clk _129_/CLK clkbuf_0_clk/X VPWR VGND sg13g2_buf_16
XFILLER_7_126 VPWR VGND sg13g2_decap_8
XFILLER_19_277 VPWR VGND sg13g2_decap_8
XFILLER_25_203 VPWR VGND sg13g2_decap_8
XFILLER_8_42 VPWR VGND sg13g2_decap_8
XFILLER_6_170 VPWR VGND sg13g2_decap_8
XFILLER_24_280 VPWR VGND sg13g2_decap_4
XFILLER_3_140 VPWR VGND sg13g2_decap_8
XFILLER_13_228 VPWR VGND sg13g2_decap_8
XFILLER_21_261 VPWR VGND sg13g2_decap_8
XFILLER_0_110 VPWR VGND sg13g2_decap_8
XFILLER_0_198 VPWR VGND sg13g2_decap_8
XFILLER_5_21 VPWR VGND sg13g2_decap_8
XFILLER_5_98 VPWR VGND sg13g2_fill_1
XFILLER_14_74 VPWR VGND sg13g2_decap_8
XFILLER_30_84 VPWR VGND sg13g2_decap_8
XFILLER_5_257 VPWR VGND sg13g2_decap_8
XFILLER_2_238 VPWR VGND sg13g2_decap_8
XFILLER_4_7 VPWR VGND sg13g2_decap_8
XFILLER_17_150 VPWR VGND sg13g2_fill_2
XFILLER_25_84 VPWR VGND sg13g2_decap_8
XFILLER_26_161 VPWR VGND sg13g2_decap_8
XFILLER_2_77 VPWR VGND sg13g2_decap_8
XFILLER_23_131 VPWR VGND sg13g2_decap_8
XFILLER_11_42 VPWR VGND sg13g2_decap_8
XFILLER_14_153 VPWR VGND sg13g2_decap_8
XFILLER_20_112 VPWR VGND sg13g2_decap_8
XFILLER_20_167 VPWR VGND sg13g2_decap_8
XFILLER_11_112 VPWR VGND sg13g2_decap_4
XFILLER_11_167 VPWR VGND sg13g2_decap_8
XFILLER_22_63 VPWR VGND sg13g2_decap_8
XFILLER_28_245 VPWR VGND sg13g2_decap_8
X_101_ _101_/Y _134_/Q _131_/Q VPWR VGND sg13g2_nand2_1
XFILLER_7_105 VPWR VGND sg13g2_decap_8
XFILLER_19_256 VPWR VGND sg13g2_decap_8
XFILLER_26_0 VPWR VGND sg13g2_decap_8
XFILLER_8_98 VPWR VGND sg13g2_decap_8
XFILLER_8_21 VPWR VGND sg13g2_decap_8
XFILLER_25_259 VPWR VGND sg13g2_decap_8
XFILLER_4_119 VPWR VGND sg13g2_decap_8
XFILLER_3_196 VPWR VGND sg13g2_decap_8
XFILLER_13_207 VPWR VGND sg13g2_decap_8
XFILLER_30_284 VPWR VGND sg13g2_decap_4
XFILLER_0_177 VPWR VGND sg13g2_decap_8
XFILLER_21_240 VPWR VGND sg13g2_decap_8
XFILLER_28_84 VPWR VGND sg13g2_decap_8
XFILLER_5_77 VPWR VGND sg13g2_decap_8
XFILLER_14_53 VPWR VGND sg13g2_decap_8
XFILLER_30_63 VPWR VGND sg13g2_decap_8
XFILLER_5_236 VPWR VGND sg13g2_decap_8
XFILLER_2_217 VPWR VGND sg13g2_decap_8
XFILLER_25_63 VPWR VGND sg13g2_decap_8
XFILLER_26_140 VPWR VGND sg13g2_decap_8
XFILLER_2_56 VPWR VGND sg13g2_decap_8
XFILLER_17_173 VPWR VGND sg13g2_decap_8
XFILLER_17_184 VPWR VGND sg13g2_fill_2
XFILLER_11_21 VPWR VGND sg13g2_decap_8
XFILLER_11_98 VPWR VGND sg13g2_decap_8
XFILLER_23_187 VPWR VGND sg13g2_decap_8
XFILLER_22_42 VPWR VGND sg13g2_decap_8
XFILLER_28_224 VPWR VGND sg13g2_decap_8
X_100_ _106_/A _100_/A _100_/B VPWR VGND sg13g2_nand2_1
XFILLER_19_235 VPWR VGND sg13g2_decap_8
XFILLER_8_77 VPWR VGND sg13g2_decap_8
XFILLER_19_0 VPWR VGND sg13g2_decap_8
XFILLER_25_238 VPWR VGND sg13g2_decap_8
XFILLER_17_53 VPWR VGND sg13g2_decap_8
XFILLER_17_97 VPWR VGND sg13g2_decap_8
XFILLER_3_175 VPWR VGND sg13g2_decap_8
XFILLER_12_7 VPWR VGND sg13g2_decap_8
XFILLER_15_271 VPWR VGND sg13g2_decap_8
XFILLER_30_263 VPWR VGND sg13g2_decap_8
XFILLER_0_156 VPWR VGND sg13g2_decap_8
XFILLER_28_63 VPWR VGND sg13g2_decap_8
XFILLER_10_4 VPWR VGND sg13g2_decap_8
XFILLER_8_201 VPWR VGND sg13g2_decap_8
XFILLER_5_56 VPWR VGND sg13g2_decap_8
XFILLER_14_32 VPWR VGND sg13g2_decap_8
XFILLER_29_182 VPWR VGND sg13g2_decap_8
XFILLER_30_42 VPWR VGND sg13g2_decap_8
XFILLER_5_215 VPWR VGND sg13g2_decap_8
XFILLER_27_119 VPWR VGND sg13g2_decap_8
XFILLER_4_281 VPWR VGND sg13g2_decap_8
XFILLER_18_119 VPWR VGND sg13g2_fill_1
XFILLER_25_42 VPWR VGND sg13g2_decap_8
XFILLER_26_196 VPWR VGND sg13g2_decap_8
XFILLER_17_152 VPWR VGND sg13g2_fill_1
XFILLER_1_273 VPWR VGND sg13g2_decap_8
XFILLER_2_35 VPWR VGND sg13g2_decap_8
XFILLER_11_77 VPWR VGND sg13g2_decap_8
XFILLER_23_166 VPWR VGND sg13g2_decap_8
XFILLER_14_199 VPWR VGND sg13g2_decap_8
XFILLER_20_136 VPWR VGND sg13g2_decap_8
XFILLER_28_203 VPWR VGND sg13g2_decap_8
XFILLER_22_21 VPWR VGND sg13g2_decap_8
XFILLER_27_280 VPWR VGND sg13g2_decap_8
XFILLER_8_56 VPWR VGND sg13g2_decap_8
XFILLER_25_217 VPWR VGND sg13g2_decap_8
XFILLER_6_184 VPWR VGND sg13g2_decap_8
XFILLER_17_32 VPWR VGND sg13g2_decap_8
XFILLER_3_154 VPWR VGND sg13g2_decap_8
XFILLER_22_209 VPWR VGND sg13g2_decap_8
XFILLER_30_242 VPWR VGND sg13g2_decap_8
XFILLER_0_124 VPWR VGND sg13g2_decap_8
XFILLER_21_275 VPWR VGND sg13g2_decap_8
XFILLER_21_286 VPWR VGND sg13g2_fill_2
XFILLER_28_42 VPWR VGND sg13g2_decap_8
XFILLER_5_35 VPWR VGND sg13g2_decap_8
XFILLER_14_11 VPWR VGND sg13g2_decap_8
XFILLER_14_88 VPWR VGND sg13g2_decap_8
XFILLER_29_161 VPWR VGND sg13g2_decap_8
XFILLER_30_21 VPWR VGND sg13g2_decap_8
XFILLER_30_98 VPWR VGND sg13g2_decap_8
XFILLER_4_260 VPWR VGND sg13g2_decap_8
XFILLER_25_21 VPWR VGND sg13g2_decap_8
XFILLER_25_98 VPWR VGND sg13g2_decap_8
XFILLER_26_175 VPWR VGND sg13g2_decap_8
XFILLER_1_252 VPWR VGND sg13g2_decap_8
XFILLER_2_14 VPWR VGND sg13g2_decap_8
XFILLER_9_0 VPWR VGND sg13g2_decap_8
XFILLER_11_56 VPWR VGND sg13g2_decap_8
XFILLER_23_145 VPWR VGND sg13g2_decap_8
XFILLER_2_7 VPWR VGND sg13g2_decap_8
XFILLER_14_123 VPWR VGND sg13g2_decap_8
XFILLER_14_167 VPWR VGND sg13g2_decap_8
XFILLER_28_259 VPWR VGND sg13g2_decap_8
XFILLER_22_77 VPWR VGND sg13g2_decap_8
XFILLER_7_119 VPWR VGND sg13g2_decap_8
XFILLER_18_281 VPWR VGND sg13g2_decap_8
X_089_ _094_/B _089_/A _089_/B VPWR VGND sg13g2_xor2_1
XFILLER_8_35 VPWR VGND sg13g2_decap_8
XFILLER_6_163 VPWR VGND sg13g2_decap_8
XFILLER_16_218 VPWR VGND sg13g2_decap_8
XFILLER_17_11 VPWR VGND sg13g2_decap_8
XFILLER_24_273 VPWR VGND sg13g2_decap_8
XFILLER_30_221 VPWR VGND sg13g2_decap_8
XFILLER_3_133 VPWR VGND sg13g2_decap_8
XFILLER_0_103 VPWR VGND sg13g2_decap_8
XFILLER_0_91 VPWR VGND sg13g2_decap_4
XFILLER_21_254 VPWR VGND sg13g2_decap_8
XFILLER_24_0 VPWR VGND sg13g2_decap_8
XFILLER_28_21 VPWR VGND sg13g2_decap_8
XFILLER_28_98 VPWR VGND sg13g2_decap_8
XFILLER_5_14 VPWR VGND sg13g2_decap_8
XFILLER_14_67 VPWR VGND sg13g2_decap_8
XFILLER_29_140 VPWR VGND sg13g2_decap_8
XFILLER_30_77 VPWR VGND sg13g2_decap_8
XFILLER_25_77 VPWR VGND sg13g2_decap_8
XFILLER_26_154 VPWR VGND sg13g2_decap_8
XFILLER_17_143 VPWR VGND sg13g2_decap_8
XFILLER_1_231 VPWR VGND sg13g2_decap_8
XFILLER_11_35 VPWR VGND sg13g2_decap_8
XFILLER_23_124 VPWR VGND sg13g2_decap_8
XFILLER_14_102 VPWR VGND sg13g2_decap_8
XFILLER_14_146 VPWR VGND sg13g2_decap_8
XFILLER_20_105 VPWR VGND sg13g2_fill_2
XFILLER_28_7 VPWR VGND sg13g2_decap_8
XFILLER_9_161 VPWR VGND sg13g2_fill_2
XFILLER_11_105 VPWR VGND sg13g2_decap_8
XFILLER_11_116 VPWR VGND sg13g2_fill_2
XFILLER_22_56 VPWR VGND sg13g2_decap_8
XFILLER_28_238 VPWR VGND sg13g2_decap_8
XFILLER_3_91 VPWR VGND sg13g2_decap_8
XFILLER_10_171 VPWR VGND sg13g2_fill_2
XFILLER_18_260 VPWR VGND sg13g2_decap_8
XFILLER_19_249 VPWR VGND sg13g2_decap_8
X_088_ _088_/Y _105_/A VPWR VGND sg13g2_inv_1
XFILLER_8_14 VPWR VGND sg13g2_decap_8
XFILLER_6_142 VPWR VGND sg13g2_decap_8
XFILLER_17_67 VPWR VGND sg13g2_fill_2
XFILLER_24_252 VPWR VGND sg13g2_decap_8
XFILLER_15_285 VPWR VGND sg13g2_fill_2
XFILLER_30_200 VPWR VGND sg13g2_decap_8
XFILLER_3_112 VPWR VGND sg13g2_decap_8
XFILLER_3_189 VPWR VGND sg13g2_decap_8
XFILLER_0_70 VPWR VGND sg13g2_decap_8
XFILLER_21_211 VPWR VGND sg13g2_decap_8
XFILLER_30_277 VPWR VGND sg13g2_decap_8
XFILLER_12_277 VPWR VGND sg13g2_decap_8
XFILLER_28_77 VPWR VGND sg13g2_decap_8
XFILLER_8_237 VPWR VGND sg13g2_decap_4
XFILLER_8_215 VPWR VGND sg13g2_decap_4
XFILLER_14_46 VPWR VGND sg13g2_decap_8
XFILLER_30_56 VPWR VGND sg13g2_decap_8
XFILLER_5_229 VPWR VGND sg13g2_decap_8
XFILLER_29_196 VPWR VGND sg13g2_decap_8
XFILLER_26_133 VPWR VGND sg13g2_decap_8
XFILLER_6_91 VPWR VGND sg13g2_decap_8
XFILLER_1_210 VPWR VGND sg13g2_decap_8
XFILLER_1_287 VPWR VGND sg13g2_fill_1
XFILLER_25_56 VPWR VGND sg13g2_decap_8
XFILLER_2_49 VPWR VGND sg13g2_decap_8
XFILLER_11_14 VPWR VGND sg13g2_decap_8
XFILLER_9_195 VPWR VGND sg13g2_decap_8
XFILLER_9_173 VPWR VGND sg13g2_fill_2
XFILLER_9_140 VPWR VGND sg13g2_decap_8
XFILLER_22_35 VPWR VGND sg13g2_decap_8
XFILLER_28_217 VPWR VGND sg13g2_decap_8
XFILLER_3_70 VPWR VGND sg13g2_decap_8
XFILLER_19_228 VPWR VGND sg13g2_decap_8
X_087_ _105_/A _089_/A _089_/B VPWR VGND sg13g2_and2_1
XFILLER_6_198 VPWR VGND sg13g2_decap_8
XFILLER_17_46 VPWR VGND sg13g2_decap_8
XFILLER_24_231 VPWR VGND sg13g2_decap_8
XFILLER_3_168 VPWR VGND sg13g2_decap_8
XFILLER_15_264 VPWR VGND sg13g2_decap_8
XFILLER_30_256 VPWR VGND sg13g2_decap_8
XFILLER_0_138 VPWR VGND sg13g2_decap_8
XFILLER_0_149 VPWR VGND sg13g2_decap_8
XFILLER_12_212 VPWR VGND sg13g2_fill_1
XFILLER_12_234 VPWR VGND sg13g2_decap_4
XFILLER_28_56 VPWR VGND sg13g2_decap_8
XFILLER_9_91 VPWR VGND sg13g2_decap_8
Xclkbuf_2_3__f_clk _125_/CLK clkbuf_0_clk/X VPWR VGND sg13g2_buf_16
XFILLER_5_49 VPWR VGND sg13g2_decap_8
XFILLER_14_25 VPWR VGND sg13g2_decap_8
XFILLER_30_35 VPWR VGND sg13g2_decap_8
XFILLER_5_208 VPWR VGND sg13g2_decap_8
XFILLER_29_175 VPWR VGND sg13g2_decap_8
XFILLER_4_274 VPWR VGND sg13g2_decap_8
XFILLER_6_70 VPWR VGND sg13g2_decap_8
XFILLER_1_266 VPWR VGND sg13g2_decap_8
XFILLER_25_35 VPWR VGND sg13g2_decap_8
XFILLER_26_112 VPWR VGND sg13g2_decap_8
XFILLER_26_189 VPWR VGND sg13g2_decap_8
XFILLER_2_28 VPWR VGND sg13g2_decap_8
XFILLER_23_159 VPWR VGND sg13g2_decap_8
XFILLER_20_129 VPWR VGND sg13g2_decap_8
XFILLER_7_0 VPWR VGND sg13g2_decap_8
XFILLER_22_14 VPWR VGND sg13g2_decap_8
XFILLER_0_7 VPWR VGND sg13g2_decap_8
XFILLER_12_91 VPWR VGND sg13g2_decap_8
XFILLER_27_273 VPWR VGND sg13g2_decap_8
X_086_ _089_/B _102_/S _086_/B VPWR VGND sg13g2_nand2b_1
XFILLER_8_49 VPWR VGND sg13g2_decap_8
XFILLER_6_177 VPWR VGND sg13g2_decap_8
XFILLER_6_100 VPWR VGND sg13g2_fill_1
XFILLER_17_25 VPWR VGND sg13g2_decap_8
XFILLER_17_69 VPWR VGND sg13g2_fill_1
XFILLER_24_210 VPWR VGND sg13g2_decap_8
XFILLER_3_147 VPWR VGND sg13g2_decap_8
XFILLER_15_287 VPWR VGND sg13g2_fill_1
XFILLER_30_235 VPWR VGND sg13g2_decap_8
X_069_ _074_/A _132_/Q _131_/Q VPWR VGND sg13g2_nand2_1
XFILLER_0_117 VPWR VGND sg13g2_decap_8
XFILLER_21_268 VPWR VGND sg13g2_decap_8
XFILLER_28_35 VPWR VGND sg13g2_decap_8
XFILLER_9_70 VPWR VGND sg13g2_decap_8
XFILLER_5_28 VPWR VGND sg13g2_decap_8
XFILLER_22_0 VPWR VGND sg13g2_decap_8
XFILLER_29_154 VPWR VGND sg13g2_decap_8
XFILLER_30_14 VPWR VGND sg13g2_decap_8
XFILLER_20_91 VPWR VGND sg13g2_decap_8
XFILLER_4_253 VPWR VGND sg13g2_decap_8
XFILLER_1_245 VPWR VGND sg13g2_decap_8
XFILLER_25_14 VPWR VGND sg13g2_decap_8
XFILLER_26_168 VPWR VGND sg13g2_decap_8
XFILLER_17_157 VPWR VGND sg13g2_decap_8
XFILLER_11_49 VPWR VGND sg13g2_decap_8
XFILLER_16_190 VPWR VGND sg13g2_fill_2
XFILLER_23_138 VPWR VGND sg13g2_decap_8
XFILLER_14_116 VPWR VGND sg13g2_decap_8
XFILLER_22_193 VPWR VGND sg13g2_fill_1
XFILLER_13_193 VPWR VGND sg13g2_decap_8
XFILLER_20_119 VPWR VGND sg13g2_fill_1
XFILLER_10_141 VPWR VGND sg13g2_decap_4
XFILLER_27_252 VPWR VGND sg13g2_decap_8
XFILLER_8_28 VPWR VGND sg13g2_decap_8
XFILLER_10_185 VPWR VGND sg13g2_fill_2
XFILLER_10_196 VPWR VGND sg13g2_decap_8
XFILLER_12_70 VPWR VGND sg13g2_decap_8
XFILLER_18_274 VPWR VGND sg13g2_decap_8
XFILLER_26_7 VPWR VGND sg13g2_decap_8
X_085_ _086_/B _062_/A _062_/C _084_/Y VPWR VGND sg13g2_o21ai_1
XFILLER_6_156 VPWR VGND sg13g2_decap_8
XFILLER_24_266 VPWR VGND sg13g2_decap_8
XFILLER_3_126 VPWR VGND sg13g2_decap_8
XFILLER_23_91 VPWR VGND sg13g2_decap_4
XFILLER_30_214 VPWR VGND sg13g2_decap_8
X_068_ _077_/A _129_/Q _134_/Q VPWR VGND sg13g2_and2_1
XFILLER_0_84 VPWR VGND sg13g2_decap_8
XFILLER_21_225 VPWR VGND sg13g2_decap_8
XFILLER_21_247 VPWR VGND sg13g2_decap_8
XFILLER_28_14 VPWR VGND sg13g2_decap_8
XFILLER_12_247 VPWR VGND sg13g2_fill_2
XFILLER_15_0 VPWR VGND sg13g2_decap_8
XFILLER_18_91 VPWR VGND sg13g2_decap_8
XFILLER_7_262 VPWR VGND sg13g2_decap_8
XFILLER_29_133 VPWR VGND sg13g2_decap_8
XFILLER_20_70 VPWR VGND sg13g2_decap_8
XFILLER_4_232 VPWR VGND sg13g2_decap_8
XFILLER_26_147 VPWR VGND sg13g2_decap_8
XFILLER_15_70 VPWR VGND sg13g2_fill_2
XFILLER_1_224 VPWR VGND sg13g2_decap_8
XFILLER_11_28 VPWR VGND sg13g2_decap_8
XFILLER_14_139 VPWR VGND sg13g2_decap_8
XFILLER_22_172 VPWR VGND sg13g2_decap_8
XFILLER_13_183 VPWR VGND sg13g2_decap_4
XFILLER_26_91 VPWR VGND sg13g2_decap_8
XFILLER_9_154 VPWR VGND sg13g2_decap_8
XFILLER_3_84 VPWR VGND sg13g2_decap_8
XFILLER_22_49 VPWR VGND sg13g2_decap_8
XFILLER_27_231 VPWR VGND sg13g2_decap_8
XFILLER_10_120 VPWR VGND sg13g2_decap_8
XFILLER_10_131 VPWR VGND sg13g2_fill_2
XFILLER_18_253 VPWR VGND sg13g2_decap_8
XFILLER_19_7 VPWR VGND sg13g2_decap_8
X_084_ _084_/Y _131_/Q _133_/Q VPWR VGND sg13g2_nand2_1
XFILLER_6_135 VPWR VGND sg13g2_decap_8
XFILLER_24_245 VPWR VGND sg13g2_decap_8
XFILLER_15_278 VPWR VGND sg13g2_decap_8
XFILLER_23_70 VPWR VGND sg13g2_decap_8
XFILLER_3_105 VPWR VGND sg13g2_decap_8
XFILLER_0_63 VPWR VGND sg13g2_decap_8
XFILLER_17_4 VPWR VGND sg13g2_decap_8
XFILLER_21_204 VPWR VGND sg13g2_decap_8
XFILLER_2_182 VPWR VGND sg13g2_decap_8
X_067_ _067_/Y _128_/Q _100_/A VPWR VGND sg13g2_nand2_1
XFILLER_20_281 VPWR VGND sg13g2_decap_8
XFILLER_8_219 VPWR VGND sg13g2_fill_2
XFILLER_8_208 VPWR VGND sg13g2_decap_8
XFILLER_18_70 VPWR VGND sg13g2_decap_8
X_119_ _119_/Y _120_/D _060_/X hold27/X VPWR VGND sg13g2_a21oi_1
XFILLER_7_230 VPWR VGND sg13g2_decap_4
XFILLER_14_39 VPWR VGND sg13g2_decap_8
XFILLER_29_112 VPWR VGND sg13g2_decap_8
XFILLER_29_189 VPWR VGND sg13g2_decap_8
XFILLER_30_49 VPWR VGND sg13g2_decap_8
XFILLER_29_91 VPWR VGND sg13g2_decap_8
XFILLER_4_211 VPWR VGND sg13g2_decap_8
XFILLER_25_49 VPWR VGND sg13g2_decap_8
XFILLER_26_126 VPWR VGND sg13g2_decap_8
XFILLER_6_84 VPWR VGND sg13g2_decap_8
XFILLER_17_104 VPWR VGND sg13g2_fill_1
XFILLER_1_203 VPWR VGND sg13g2_decap_8
XFILLER_16_192 VPWR VGND sg13g2_fill_1
XFILLER_22_151 VPWR VGND sg13g2_decap_8
XFILLER_13_162 VPWR VGND sg13g2_decap_8
XFILLER_26_70 VPWR VGND sg13g2_decap_8
XFILLER_9_188 VPWR VGND sg13g2_decap_8
XFILLER_9_133 VPWR VGND sg13g2_decap_8
XFILLER_3_63 VPWR VGND sg13g2_decap_8
XFILLER_22_28 VPWR VGND sg13g2_decap_8
XFILLER_27_210 VPWR VGND sg13g2_decap_8
XFILLER_10_154 VPWR VGND sg13g2_fill_2
XFILLER_18_232 VPWR VGND sg13g2_decap_8
XFILLER_27_287 VPWR VGND sg13g2_fill_1
X_083_ _102_/S _073_/S _072_/Y _074_/A VPWR VGND sg13g2_a21oi_1
XFILLER_5_0 VPWR VGND sg13g2_decap_8
XFILLER_17_39 VPWR VGND sg13g2_decap_8
XFILLER_24_224 VPWR VGND sg13g2_decap_8
XFILLER_5_180 VPWR VGND sg13g2_decap_8
XFILLER_15_235 VPWR VGND sg13g2_fill_2
XFILLER_15_257 VPWR VGND sg13g2_decap_8
XFILLER_30_249 VPWR VGND sg13g2_decap_8
XFILLER_0_42 VPWR VGND sg13g2_decap_8
XFILLER_2_161 VPWR VGND sg13g2_decap_8
X_135_ _135_/Q _135_/CLK _135_/D fanout19/X VPWR VGND sg13g2_dfrbpq_1
X_066_ _066_/Y _078_/A hold37/X VPWR VGND sg13g2_nor2b_1
XFILLER_9_84 VPWR VGND sg13g2_decap_8
XFILLER_12_205 VPWR VGND sg13g2_decap_8
XFILLER_12_227 VPWR VGND sg13g2_decap_8
XFILLER_12_249 VPWR VGND sg13g2_fill_1
XFILLER_20_260 VPWR VGND sg13g2_decap_8
XFILLER_28_49 VPWR VGND sg13g2_decap_8
XFILLER_11_282 VPWR VGND sg13g2_decap_4
X_118_ _118_/Y _128_/Q _133_/Q _071_/X VPWR VGND sg13g2_a21oi_1
XFILLER_14_18 VPWR VGND sg13g2_decap_8
XFILLER_30_28 VPWR VGND sg13g2_decap_8
XFILLER_29_168 VPWR VGND sg13g2_decap_8
XFILLER_29_70 VPWR VGND sg13g2_decap_8
XFILLER_4_267 VPWR VGND sg13g2_decap_8
XFILLER_20_0 VPWR VGND sg13g2_decap_8
XFILLER_26_105 VPWR VGND sg13g2_decap_8
XFILLER_6_63 VPWR VGND sg13g2_decap_8
XFILLER_17_116 VPWR VGND sg13g2_fill_2
XFILLER_1_259 VPWR VGND sg13g2_decap_8
XFILLER_25_182 VPWR VGND sg13g2_decap_8
XFILLER_25_28 VPWR VGND sg13g2_decap_8
XFILLER_9_7 VPWR VGND sg13g2_decap_8
XFILLER_15_72 VPWR VGND sg13g2_fill_1
XFILLER_22_130 VPWR VGND sg13g2_decap_8
XFILLER_9_112 VPWR VGND sg13g2_decap_8
XFILLER_3_42 VPWR VGND sg13g2_decap_8
XFILLER_12_84 VPWR VGND sg13g2_decap_8
XFILLER_27_266 VPWR VGND sg13g2_decap_8
X_082_ _089_/A _134_/Q _130_/Q VPWR VGND sg13g2_nand2_1
XFILLER_17_18 VPWR VGND sg13g2_decap_8
XFILLER_18_211 VPWR VGND sg13g2_decap_8
XFILLER_24_203 VPWR VGND sg13g2_decap_8
XFILLER_0_21 VPWR VGND sg13g2_decap_8
XFILLER_15_247 VPWR VGND sg13g2_fill_1
XFILLER_24_7 VPWR VGND sg13g2_decap_8
XFILLER_2_140 VPWR VGND sg13g2_decap_8
XFILLER_30_228 VPWR VGND sg13g2_decap_8
X_134_ _134_/Q _135_/CLK _134_/D fanout18/X VPWR VGND sg13g2_dfrbpq_1
X_065_ _065_/Y _064_/B _064_/C _064_/A VPWR VGND sg13g2_o21ai_1
XFILLER_28_28 VPWR VGND sg13g2_decap_8
XFILLER_9_63 VPWR VGND sg13g2_decap_8
XFILLER_11_261 VPWR VGND sg13g2_decap_8
X_117_ _126_/D _117_/A _117_/B VPWR VGND sg13g2_xnor2_1
XFILLER_7_276 VPWR VGND sg13g2_decap_4
XFILLER_20_84 VPWR VGND sg13g2_decap_8
XFILLER_29_147 VPWR VGND sg13g2_decap_8
XFILLER_4_246 VPWR VGND sg13g2_decap_8
XFILLER_6_42 VPWR VGND sg13g2_decap_8
XFILLER_13_0 VPWR VGND sg13g2_decap_8
XFILLER_1_238 VPWR VGND sg13g2_decap_8
XFILLER_0_282 VPWR VGND sg13g2_decap_4
XFILLER_25_161 VPWR VGND sg13g2_decap_8
XFILLER_14_109 VPWR VGND sg13g2_decap_8
XFILLER_16_183 VPWR VGND sg13g2_decap_8
XFILLER_13_142 VPWR VGND sg13g2_fill_1
XFILLER_22_186 VPWR VGND sg13g2_decap_8
XFILLER_3_98 VPWR VGND sg13g2_decap_8
XFILLER_3_21 VPWR VGND sg13g2_decap_8
XFILLER_10_145 VPWR VGND sg13g2_fill_1
XFILLER_10_156 VPWR VGND sg13g2_fill_1
XFILLER_10_167 VPWR VGND sg13g2_decap_4
XFILLER_10_178 VPWR VGND sg13g2_decap_8
XFILLER_12_63 VPWR VGND sg13g2_decap_8
XFILLER_27_245 VPWR VGND sg13g2_decap_8
X_081_ _097_/A _100_/A _081_/B VPWR VGND sg13g2_and2_1
XFILLER_6_149 VPWR VGND sg13g2_decap_8
XFILLER_18_267 VPWR VGND sg13g2_decap_8
XFILLER_24_259 VPWR VGND sg13g2_decap_8
XFILLER_3_119 VPWR VGND sg13g2_decap_8
XFILLER_15_237 VPWR VGND sg13g2_fill_1
XFILLER_23_84 VPWR VGND sg13g2_decap_8
XFILLER_23_95 VPWR VGND sg13g2_fill_2
XFILLER_2_196 VPWR VGND sg13g2_decap_8
XFILLER_30_207 VPWR VGND sg13g2_decap_8
X_133_ _133_/Q _133_/CLK _133_/D fanout18/X VPWR VGND sg13g2_dfrbpq_1
X_064_ _078_/A _064_/A _064_/B _064_/C VPWR VGND sg13g2_nor3_1
XFILLER_0_77 VPWR VGND sg13g2_decap_8
XFILLER_14_281 VPWR VGND sg13g2_decap_8
XFILLER_21_218 VPWR VGND sg13g2_decap_8
XFILLER_9_42 VPWR VGND sg13g2_decap_8
XFILLER_18_84 VPWR VGND sg13g2_decap_8
XFILLER_11_240 VPWR VGND sg13g2_decap_8
X_116_ _117_/B _116_/A _116_/B VPWR VGND sg13g2_xor2_1
XFILLER_29_126 VPWR VGND sg13g2_decap_8
XFILLER_20_63 VPWR VGND sg13g2_decap_8
XFILLER_6_98 VPWR VGND sg13g2_fill_2
XFILLER_6_21 VPWR VGND sg13g2_decap_8
XFILLER_4_225 VPWR VGND sg13g2_decap_8
XFILLER_1_217 VPWR VGND sg13g2_decap_8
XFILLER_3_280 VPWR VGND sg13g2_decap_8
XFILLER_0_261 VPWR VGND sg13g2_decap_8
XFILLER_15_63 VPWR VGND sg13g2_decap_8
XFILLER_25_140 VPWR VGND sg13g2_decap_8
XFILLER_16_162 VPWR VGND sg13g2_decap_8
XFILLER_22_165 VPWR VGND sg13g2_decap_8
XFILLER_26_84 VPWR VGND sg13g2_decap_8
XFILLER_13_121 VPWR VGND sg13g2_decap_8
XFILLER_13_176 VPWR VGND sg13g2_decap_8
XFILLER_13_187 VPWR VGND sg13g2_fill_2
XFILLER_9_147 VPWR VGND sg13g2_decap_8
XFILLER_3_77 VPWR VGND sg13g2_decap_8
XFILLER_10_113 VPWR VGND sg13g2_decap_8
XFILLER_27_224 VPWR VGND sg13g2_decap_8
X_080_ _080_/Y _080_/A _080_/B VPWR VGND sg13g2_xnor2_1
XFILLER_12_42 VPWR VGND sg13g2_decap_8
XFILLER_18_246 VPWR VGND sg13g2_decap_8
XFILLER_6_128 VPWR VGND sg13g2_decap_8
XFILLER_24_238 VPWR VGND sg13g2_decap_8
XFILLER_5_194 VPWR VGND sg13g2_decap_8
XFILLER_23_63 VPWR VGND sg13g2_decap_8
XFILLER_2_175 VPWR VGND sg13g2_decap_8
XFILLER_3_0 VPWR VGND sg13g2_decap_8
X_132_ _132_/Q _133_/CLK _132_/D fanout18/X VPWR VGND sg13g2_dfrbpq_1
X_063_ _064_/C _132_/Q _130_/Q _059_/A _060_/X VPWR VGND sg13g2_a22oi_1
XFILLER_0_56 VPWR VGND sg13g2_decap_8
XFILLER_14_260 VPWR VGND sg13g2_decap_8
XFILLER_9_98 VPWR VGND sg13g2_decap_8
XFILLER_9_21 VPWR VGND sg13g2_decap_8
XFILLER_18_63 VPWR VGND sg13g2_decap_8
XFILLER_20_274 VPWR VGND sg13g2_decap_8
X_115_ _127_/D hold31/X _116_/B _117_/A VPWR VGND sg13g2_a21oi_1
XFILLER_7_234 VPWR VGND sg13g2_fill_1
XFILLER_7_223 VPWR VGND sg13g2_decap_8
XFILLER_29_105 VPWR VGND sg13g2_decap_8
XFILLER_20_42 VPWR VGND sg13g2_decap_8
XFILLER_28_182 VPWR VGND sg13g2_decap_8
XFILLER_29_84 VPWR VGND sg13g2_decap_8
Xhold40 _100_/B _130_/Q VPWR VGND sg13g2_dlygate4sd3_1
XFILLER_4_204 VPWR VGND sg13g2_decap_8
XFILLER_19_193 VPWR VGND sg13g2_decap_8
XFILLER_26_119 VPWR VGND sg13g2_decap_8
XFILLER_6_77 VPWR VGND sg13g2_decap_8
XFILLER_15_42 VPWR VGND sg13g2_decap_8
XFILLER_25_196 VPWR VGND sg13g2_decap_8
XFILLER_0_240 VPWR VGND sg13g2_decap_8
XFILLER_16_130 VPWR VGND sg13g2_fill_2
.ends
